** sch_path: /mnt/c/Users/si150/eda/designs/heichips26-analog-workshop/amplifier/testbenches/xschem/amplifier_tb_ac_ol.sch
**.subckt amplifier_tb_ac_ol
VDD VDD GND {VDD}
vin vin GND dc {Vcm} ac 1
C1 vout GND {Cload}
x1 VDD vin vout GND amplifier
**** begin user architecture code

.include ../../../netlist/pex/amplifier_magic_pex_3.spice
.param VDD=1.5
.param Vcm=VDD/2
.param temp=27
.param Cload=10p
.param Rload=1k
.options savecurrents klu method=gear reltol=1e-4 abstol=1e-15 gmin=1e-15
.control

save all

set wr_vecnames
set wr_singlescale

* User Constants
let f_min = 0.1
let f_max = 10G
let fdc = 1

* Operating Point Analysis
op
remzerovec
write amplifier_tb_ac_ol.raw
set appendwrite

* AC Analysis
ac dec 101 $&const.f_min $&const.f_max
remzerovec
write amplifier_tb_ac_ol.raw

* Plotting
let Aol = v(vout)/v(vin)
let Aol_dB = vdb(Aol)
let Aol_arg = 180/PI*cphase(Aol)

plot Aol_dB ylabel 'Magnitude'
plot Aol_arg ylabel 'Phase'
plot Aol_dB Aol_arg ylabel 'Magnitude, Phase'

* Measurements
* DC open-loop gain
meas ac Adc_ol_dB find Aol_dB when frequency = fdc
print Adc_ol_dB

* 3dB cut-off frequency
let Aol_fc = Adc_ol_dB - 3
meas ac fc find frequency when Aol_dB = Aol_fc
print fc

* Unity Gain Bandwidth (Aol=1 or Aol_dB = 0dB)
meas ac UGB when Aol_dB=0  fall=1
print UGB

* Phase Margin at Aol=1 or Aol_dB = 0dB
meas ac arg_0dB find Aol_arg when Aol_dB=0
let PM = 180-abs(arg_0dB)
print PM

* Write Data
unset appendwrite
set wr_vecnames
set wr_singlescale
wrdata ../plot_simulations/data/amplifier_tb_ac_ol.txt v(Aol_dB) v(Aol_arg)

*quit
.endc

.lib cornerMOSlv.lib mos_tt
.lib cornerMOShv.lib mos_tt
.lib cornerRES.lib res_typ
.lib cornerDIO.lib dio_tt

**** end user architecture code
**.ends

* expanding   symbol:  amplifier.sym # of pins=4
** sym_path: /mnt/c/Users/si150/eda/designs/heichips26-analog-workshop/amplifier/schematic/xschem/amplifier.sym
** sch_path: /mnt/c/Users/si150/eda/designs/heichips26-analog-workshop/amplifier/schematic/xschem/amplifier.sch
.subckt amplifier VDD vin vout VSS
*.ipin vin
*.iopin VDD
*.iopin VSS
*.iopin vout
x1 VDD vin vout VSS inverter
XR1 vin vout VSS rhigh w=0.5e-6 l=25e-6 m=1 b=0 mm_ok=1
.ends

* expanding   symbol:  inverter.sym # of pins=4
** sym_path: /mnt/c/Users/si150/eda/designs/heichips26-analog-workshop/amplifier/schematic/xschem/inverter.sym
** sch_path: /mnt/c/Users/si150/eda/designs/heichips26-analog-workshop/amplifier/schematic/xschem/inverter.sch
.subckt inverter VDD vin vout VSS
*.ipin vin
*.iopin VDD
*.iopin VSS
*.iopin vout
XMdummy1 VSS VSS VSS VSS sg13_lv_nmos w=2.0u l=1.0u ng=2 m=1 mm_ok=1
XMdummy2 VDD VDD VDD VDD sg13_lv_pmos w=12.0u l=1.0u ng=2 m=1 mm_ok=1
XM1 vout vin VSS VSS sg13_lv_nmos w=20.0u l=1.0u ng=20 m=1 mm_ok=1
XM2 vout vin VDD VDD sg13_lv_pmos w=120.0u l=1.0u ng=20 m=1 mm_ok=1
.ends

.GLOBAL GND
.GLOBAL VDD
.end
