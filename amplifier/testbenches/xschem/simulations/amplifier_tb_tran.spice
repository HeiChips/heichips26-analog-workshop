** sch_path: /mnt/c/Users/si150/eda/designs/heichips26-analog-workshop/amplifier/testbenches/xschem/amplifier_tb_tran.sch
**.subckt amplifier_tb_tran
VDD VDD GND {VDD}
vsine vin GND sin({Vcm} 10m 1k)
C1 vout GND {Cload}
x1 VDD vin vout GND amplifier
**** begin user architecture code

.include ../../../netlist/pex/amplifier_magic_pex_3.spice
.param VDD=1.5
.csparam VDD=VDD
.param Vcm=VDD/2
.param temp=27
.param Cload=10p
.param Rload=1k
.options savecurrents klu method=gear reltol=1e-4 abstol=1e-15 gmin=1e-15
.control

save all

* Operating Point Analysis
op
remzerovec
write amplifier_tb_tran.raw
set appendwrite

* Transient Analysis
tran 1u 5m
write amplifier_tb_tran.raw

* Plotting
plot vin vout
plot i(VDD)

* Measurements
meas tran vin_peak MAX v(vin)
meas tran vout_peak MAX v(vout)

let Adm = vout_peak / vin_peak
let Adm_dB = vdb(Adm)
print Adm_dB

meas tran vout_pp_max MAX v(vout)
meas tran vout_pp_min MIN v(vout)
let vout_pp = vout_pp_max - vout_pp_min
print vout_pp

* Write Data
unset appendwrite
set wr_vecnames
set wr_singlescale
wrdata ../plot_simulations/data/amplifier_tb_tran.txt v(vin) v(vout)

*quit
.endc

.lib cornerMOSlv.lib mos_tt
.lib cornerMOShv.lib mos_tt
.lib cornerRES.lib res_typ
.lib cornerDIO.lib dio_tt

**** end user architecture code
**.ends

* expanding   symbol:  amplifier.sym # of pins=4
** sym_path: /mnt/c/Users/si150/eda/designs/heichips26-analog-workshop/amplifier/schematic/xschem/amplifier.sym
** sch_path: /mnt/c/Users/si150/eda/designs/heichips26-analog-workshop/amplifier/schematic/xschem/amplifier.sch
.subckt amplifier VDD vin vout VSS
*.ipin vin
*.iopin VDD
*.iopin VSS
*.iopin vout
x1 VDD vin vout VSS inverter
XR1 vin vout VSS rhigh w=0.5e-6 l=25e-6 m=1 b=0 mm_ok=1
.ends

* expanding   symbol:  inverter.sym # of pins=4
** sym_path: /mnt/c/Users/si150/eda/designs/heichips26-analog-workshop/amplifier/schematic/xschem/inverter.sym
** sch_path: /mnt/c/Users/si150/eda/designs/heichips26-analog-workshop/amplifier/schematic/xschem/inverter.sch
.subckt inverter VDD vin vout VSS
*.ipin vin
*.iopin VDD
*.iopin VSS
*.iopin vout
XMdummy1 VSS VSS VSS VSS sg13_lv_nmos w=2.0u l=1.0u ng=2 m=1 mm_ok=1
XMdummy2 VDD VDD VDD VDD sg13_lv_pmos w=12.0u l=1.0u ng=2 m=1 mm_ok=1
XM1 vout vin VSS VSS sg13_lv_nmos w=20.0u l=1.0u ng=20 m=1 mm_ok=1
XM2 vout vin VDD VDD sg13_lv_pmos w=120.0u l=1.0u ng=20 m=1 mm_ok=1
.ends

.GLOBAL GND
.GLOBAL VDD
.end
